* Simulation test
.model D_model_D1 D
.model D_model_D2 D(IS=1e-14 N=1 RS=1.2 BV=5.1 IBV=5m)
.model D_model_D3 D(IS=1e-14 N=1 RS=1.2 BV=5.1 IBV=5m)

D1 _D1_2_ 5V D_model_D1
R1 _D1_2_ 0 10k
D2 _D2_2_ 5V D_model_D2
R2 _D2_2_ 0 10k
D3 _D3_2_ 5V D_model_D3
R3 _D3_2_ 0 10k
R4 5V _R4_2_ 10k
C1 _R4_2_ 0 100n
R5 _R4_2_ 0 10k
V1 5V 0 SIN(0, 5, 10k)
.end
